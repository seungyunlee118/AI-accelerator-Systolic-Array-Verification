// SA-GEMM CSR map (spec v0.3 §4) written in SystemRDL.
// This file is the single source of truth: the UVM RAL model and the HTML register docs
// are generated from it by ral/gen.sh. Do not hand-edit the generated files.
//
// ---------------------------------------------------------------- SystemRDL cheat sheet
//   reg { field {...} NAME[msb:lsb] = reset; ... } REG_NAME @ offset;
//
//   Spec access    SystemRDL field properties                     -> UVM access
//   RW             sw = rw; hw = r;                               -> "RW"
//   RO (hw drives) sw = r;  hw = w;                               -> "RO"  (volatile)
//   RO constant    sw = r;  hw = na;                              -> "RO"
//   W (write-only) sw = w;  hw = r;  singlepulse;                 -> "WO"
//   W1C event      sw = rw; onwrite = woclr; hw = na; hwset;      -> "W1C" (volatile)
//
//   Bits you do not declare are reserved: they read 0 and ignore writes (spec §4).
//   desc = "..." is optional but makes the generated HTML docs useful.
// ----------------------------------------------------------------

addrmap sa_gemm_csr {
    name = "SA-GEMM control and status registers";
    default regwidth = 32;

    // ------------------------------------------------ examples (done)
    reg {
        name = "CTRL";
        field { desc = "Write 1 to start a job. Always reads 0."; sw = w; hw = r; singlepulse; } START[0:0] = 0;
    } CTRL @ 0x00;

    reg {
        name = "STATUS";
        field { desc = "1 while a job is running.";         sw = r; hw = w; } BUSY[0:0]     = 0;
        field { desc = "Error code of the last job (§8)."; sw = r; hw = w; } ERR_CODE[7:4] = 0;
    } STATUS @ 0x04;

    reg {
        name = "IRQ_STATUS";
        field { desc = "Set when a job succeeds. Write 1 to clear."; sw = rw; onwrite = woclr; hw = na; hwset; } DONE[0:0] = 0;
        field { desc = "Set when a job fails. Write 1 to clear.";    sw = rw; onwrite = woclr; hw = na; hwset; } ERR[1:1]  = 0;
    } IRQ_STATUS @ 0x0C;

    reg {
        name = "VERSION";
        field { desc = "Design ID / version."; sw = r; hw = na; } ID[31:0] = 0x53410002;
    } VERSION @ 0x30;

    // ------------------------------------------------ TODO: your part
    // Write the remaining 11 registers from spec §4 (offset, fields, access, reset value):
    //   IRQ_EN   @ 0x08   DONE_EN[0:0], ERR_EN[1:1]                     RW
    //   DIMS     @ 0x10   M[6:0], N[14:8], K[22:16]                      RW
    //   A_BASE   @ 0x14   [31:0]   A_STRIDE @ 0x18  [15:0]               RW
    //   B_BASE   @ 0x1C   [31:0]   B_STRIDE @ 0x20  [15:0]               RW
    //   C_BASE   @ 0x24   [31:0]   C_STRIDE @ 0x28  [15:0]               RW
    //   CYCLES   @ 0x2C   [31:0]                                         RO, driven by hardware
    //   QCFG     @ 0x34   REQ_EN[0:0], RELU_EN[1:1], SHIFT[12:8]         RW
    //   QSCALE   @ 0x38   SCALE[15:0]                                    RW
    // All reset values are 0.
};
