// SA-GEMM CSR map (spec v0.3 §4) written in SystemRDL.
// This file is the single source of truth: the UVM RAL model and the HTML register docs
// are generated from it by ral/gen.sh. Do not hand-edit the generated files.
//
// ---------------------------------------------------------------- SystemRDL cheat sheet
//   reg { field {...} NAME[msb:lsb] = reset; ... } REG_NAME @ offset;
//
//   Spec access    SystemRDL field properties                     -> UVM access
//   RW             sw = rw; hw = r;                               -> "RW"
//   RO (hw drives) sw = r;  hw = w;                               -> "RO"  (volatile)
//   RO constant    sw = r;  hw = na;                              -> "RO"
//   W (write-only) sw = w;  hw = r;  singlepulse;                 -> "WO"
//   W1C event      sw = rw; onwrite = woclr; hw = na; hwset;      -> "W1C" (volatile)
//
//   Bits you do not declare are reserved: they read 0 and ignore writes (spec §4).
//   desc = "..." is optional but makes the generated HTML docs useful.
// ----------------------------------------------------------------

addrmap sa_gemm_csr {
    name = "SA-GEMM control and status registers";
    default regwidth = 32;

    // ------------------------------------------------ control and status
    reg {
        name = "CTRL";
        field { desc = "Write 1 to start a job. Always reads 0."; sw = w; hw = r; singlepulse; } START[0:0] = 0;
    } CTRL @ 0x00;

    reg {
        name = "STATUS";
        field { desc = "1 while a job is running.";         sw = r; hw = w; } BUSY[0:0]     = 0;
        field { desc = "Error code of the last job (§8)."; sw = r; hw = w; } ERR_CODE[7:4] = 0;
    } STATUS @ 0x04;

    // ------------------------------------------------ interrupts
    reg {
        name = "IRQ_EN";
        field { desc = "Raise irq when IRQ_STATUS.DONE is set."; sw = rw; hw = r; } DONE_EN[0:0] = 0;
        field { desc = "Raise irq when IRQ_STATUS.ERR is set.";  sw = rw; hw = r; } ERR_EN[1:1]  = 0;
    } IRQ_EN @ 0x08;

    reg {
        name = "IRQ_STATUS";
        field { desc = "Set when a job succeeds. Write 1 to clear."; sw = rw; onwrite = woclr; hw = na; hwset; } DONE[0:0] = 0;
        field { desc = "Set when a job fails. Write 1 to clear.";    sw = rw; onwrite = woclr; hw = na; hwset; } ERR[1:1]  = 0;
    } IRQ_STATUS @ 0x0C;

    // ------------------------------------------------ job configuration (sampled at START)
    reg {
        name = "DIMS";
        field { desc = "Rows of A and C (valid 1..64).";            sw = rw; hw = r; } M[6:0]   = 0;
        field { desc = "Columns of B and C (valid 1..64).";         sw = rw; hw = r; } N[14:8]  = 0;
        field { desc = "Columns of A, rows of B (valid 1..64).";    sw = rw; hw = r; } K[22:16] = 0;
    } DIMS @ 0x10;

    reg { name = "A_BASE";
        field { desc = "Byte address of A[0][0] (multiple of 8)."; sw = rw; hw = r; } ADDR[31:0] = 0;
    } A_BASE @ 0x14;
    reg { name = "A_STRIDE";
        field { desc = "Bytes between A rows (multiple of 8).";    sw = rw; hw = r; } STRIDE[15:0] = 0;
    } A_STRIDE @ 0x18;

    reg { name = "B_BASE";
        field { desc = "Byte address of B[0][0] (multiple of 8)."; sw = rw; hw = r; } ADDR[31:0] = 0;
    } B_BASE @ 0x1C;
    reg { name = "B_STRIDE";
        field { desc = "Bytes between B rows (multiple of 8).";    sw = rw; hw = r; } STRIDE[15:0] = 0;
    } B_STRIDE @ 0x20;

    reg { name = "C_BASE";
        field { desc = "Byte address of C[0][0] (multiple of 8)."; sw = rw; hw = r; } ADDR[31:0] = 0;
    } C_BASE @ 0x24;
    reg { name = "C_STRIDE";
        field { desc = "Bytes between C rows (multiple of 8, at least E*N)."; sw = rw; hw = r; } STRIDE[15:0] = 0;
    } C_STRIDE @ 0x28;

    // ------------------------------------------------ status, identification, output stage
    reg {
        name = "CYCLES";
        field { desc = "Clock cycles BUSY was high during the last job."; sw = r; hw = w; } COUNT[31:0] = 0;
    } CYCLES @ 0x2C;

    reg {
        name = "VERSION";
        field { desc = "Design ID / version."; sw = r; hw = na; } ID[31:0] = 0x53410002;
    } VERSION @ 0x30;

    reg {
        name = "QCFG";
        field { desc = "1: requantize to INT8. 0: write INT32.";       sw = rw; hw = r; } REQ_EN[0:0]  = 0;
        field { desc = "1: apply ReLU (negative results become 0).";  sw = rw; hw = r; } RELU_EN[1:1] = 0;
        field { desc = "Right shift used by requantization (0..31)."; sw = rw; hw = r; } SHIFT[12:8]  = 0;
    } QCFG @ 0x34;

    reg {
        name = "QSCALE";
        field { desc = "Unsigned requantization multiplier."; sw = rw; hw = r; } SCALE[15:0] = 0;
    } QSCALE @ 0x38;
};
